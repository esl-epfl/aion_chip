* ================================================================
*  SPDX-FileCopyrightText:    2026 Filippo Quadri
*  SPDX-License-Identifier:   Apache-2.0 WITH SHL-2.1
*  Description:               AION_mux2i_1 -- transmission-gate 2:1 mux
*
*  An INVERTING 2:1 multiplexer in 8 devices, against the 12 the PDK needs
*  for the non-inverting one.
*
*      O0 = !I0 when I2 = 0,   O0 = !I1 when I2 = 1
*
*  Why a transmission gate wins here.  The PDK builds mux2 the only way
*  complementary CMOS can: a select inverter, an AOI22 core and an output
*  inverter, 2 + 8 + 2 = 12 devices.  A pair of transmission gates does the
*  same selection in 4, because a TG steers a signal rather than
*  re-deriving it from the rails.
*
*  Why the output inverter stays, and why the second one does not.  The
*  inverter is not here for drive strength -- a full transmission gate
*  passes both rails without a threshold drop, so levels need no restoring.
*  It is here to make the cell *modelable*.  A Liberty arc says
*  delay = f(input slew, output load), which is exact when a cell's input is
*  a transistor gate: the capacitance isolates and the driver's job ends
*  with the waveform.  A pass gate's input is a source/drain, so the driver
*  stays in series with the TG for the whole transition and two drivers of
*  equal slew but different impedance give different delays -- something
*  NLDM has no axis for.  With the inverter, the TG only ever charges node m
*  plus one gate, a fixed and small internal load, so that sensitivity is
*  bounded and everything downstream sees an ordinary CMOS output.
*
*  A second inverter would restore the non-inverting polarity, but it also
*  raises VDD to degree three in the device graph, which forces a second
*  diffusion break and costs two more CoreSites -- 9 instead of 7, taking
*  the saving against the PDK cell from 3 sites down to 1.  Polarity is
*  cheaper to fix in the mapper than in the layout.
*
*  Characterize this cell with aion_char's --driver-cell rather than the
*  default ideal ramp: a linear ramp is a zero-impedance driver, which is
*  the most optimistic case there is for anything with a pass gate in it.
*
*  Devices are single fingers at the library's own widths (nmos 740 nm,
*  pmos 1120 nm) so both rows are unbroken-height diffusion strips and the
*  extracted widths match this netlist exactly.  ad/as/pd/ps are the PDK's
*  own values for those widths, taken from sg13g2_inv_1.
*
*  Port order matches the AION convention that aion_layout's LVS reads:
*      I0 = A0   I1 = A1   I2 = S   O0 = !X
* ================================================================
.subckt AION_mux2i_1 I0 I1 I2 O0 VDD VSS
* ---- select inverter:  Sb = !I2 ---------------------------------------
XP0 Sb I2 VDD VDD sg13_lv_pmos w=1.12u   l=130.00n ng=1 m=1 ad=3.808e-13 as=3.808e-13 pd=2.92e-06 ps=2.92e-06
XN0 Sb I2 VSS VSS sg13_lv_nmos w=740.00n l=130.00n ng=1 m=1 ad=2.516e-13 as=2.516e-13 pd=2.16e-06 ps=2.16e-06
* ---- TG0: conducts when I2 = 0, steers I0 onto m ----------------------
XN1 m  Sb I0 VSS sg13_lv_nmos w=740.00n l=130.00n ng=1 m=1 ad=2.516e-13 as=2.516e-13 pd=2.16e-06 ps=2.16e-06
XP1 m  I2 I0 VDD sg13_lv_pmos w=1.12u   l=130.00n ng=1 m=1 ad=3.808e-13 as=3.808e-13 pd=2.92e-06 ps=2.92e-06
* ---- TG1: conducts when I2 = 1, steers I1 onto m ----------------------
XN2 m  I2 I1 VSS sg13_lv_nmos w=740.00n l=130.00n ng=1 m=1 ad=2.516e-13 as=2.516e-13 pd=2.16e-06 ps=2.16e-06
XP2 m  Sb I1 VDD sg13_lv_pmos w=1.12u   l=130.00n ng=1 m=1 ad=3.808e-13 as=3.808e-13 pd=2.92e-06 ps=2.92e-06
* ---- restoring output stage:  O0 = !m ---------------------------------
XP3 O0 m  VDD VDD sg13_lv_pmos w=1.12u   l=130.00n ng=1 m=1 ad=3.808e-13 as=3.808e-13 pd=2.92e-06 ps=2.92e-06
XN3 O0 m  VSS VSS sg13_lv_nmos w=740.00n l=130.00n ng=1 m=1 ad=2.516e-13 as=2.516e-13 pd=2.16e-06 ps=2.16e-06
.ends
